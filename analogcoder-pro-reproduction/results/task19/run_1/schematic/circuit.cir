.title Gilbert Cell Mixer
Vdd Vdd 0 5.0
Vrfp Vrfp 0 2.5
Vrfn Vrfn 0 2.5
Vlop Vlop 0 4.5
Vlon Vlon 0 0.5
M9 TailNode Vbias_tail 0 0 nmos_model l=1e-06 w=2e-05
Vbias_tail Vbias_tail 0 1.0
M1 Drain1 Vrfp TailNode TailNode nmos_model l=1e-06 w=5e-05
M2 Drain2 Vrfn TailNode TailNode nmos_model l=1e-06 w=5e-05
M3 OutPNode Vlop Drain1 Drain1 nmos_model l=1e-06 w=5e-05
M4 OutPNode Vlon Drain2 Drain2 nmos_model l=1e-06 w=5e-05
M5 OutNNode Vlop Drain2 Drain2 nmos_model l=1e-06 w=5e-05
M6 OutNNode Vlon Drain1 Drain1 nmos_model l=1e-06 w=5e-05
M7 Voutp Vbias_load Vdd Vdd pmos_model l=1e-06 w=0.0001
M8 Voutn Vbias_load Vdd Vdd pmos_model l=1e-06 w=0.0001
Vbias_load Vbias_load 0 1.0
Rload_p OutPNode Voutp 1kOhm
Rload_n OutNNode Voutn 1kOhm
.model nmos_model nmos (kp=0.0001 level=1 vto=0.5)
.model pmos_model pmos (kp=5e-05 level=1 vto=-0.5)
