.title LM358 Signal Conditioner
Vsupply Vcc 0 5V
Vin Vin 0 dc 2.5 ac 0.001
Rinput Vin Vplus 15.9kOhm
Cinput Vplus 0 10nF
Vref Vref_node 0 2.5V
Eop Vout 0 Vplus Vminus 100000.0
Rfeedback Vout Vminus 40kOhm
Rground Vminus Vref_node 10kOhm
Rload Vout 0 10kOhm
Ccomp_minus Vminus 0 1pF
