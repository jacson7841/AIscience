.title Gilbert Cell Mixer - verified Task 19 design
Vdd Vdd 0 5.0
Vbias Vbias 0 1.5
Vrfp Vrfp 0 2.5
Vrfn Vrfn 0 2.5
Vlop Vlop 0 3.0
Vlon Vlon 0 2.0
RL1 Vdd Voutp 1kOhm
RL2 Vdd Voutn 1kOhm
M7 SourceNode Vbias 0 0 nmos_model l=1e-06 w=0.0001
M1 RFp_out Vrfp SourceNode 0 nmos_model l=1e-06 w=5e-05
M2 RFn_out Vrfn SourceNode 0 nmos_model l=1e-06 w=5e-05
M3 Voutp Vlop RFp_out 0 nmos_model l=1e-06 w=5e-05
M4 Voutp Vlon RFn_out 0 nmos_model l=1e-06 w=5e-05
M5 Voutn Vlon RFp_out 0 nmos_model l=1e-06 w=5e-05
M6 Voutn Vlop RFn_out 0 nmos_model l=1e-06 w=5e-05
.model nmos_model nmos (kp=0.0001 level=1 vto=0.7)
